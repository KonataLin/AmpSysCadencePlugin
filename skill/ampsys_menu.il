; ============================================================
; AmpSys Cadence Plugin - Menus
; ============================================================

procedure(ampsysAddMenu(win)
  let((m1 m2 m3 pm)
    when(and(win not(member(win _ampsysTagged)))
      ampsysLog(sprintf(nil "Adding menu to window=%L" win))
      m1 = hiCreateMenuItem(?name gensym("ampsysM") ?itemText "Open AmpSys GUI" ?callback "ampsysOpenGUIOnly()")
      m2 = hiCreateMenuItem(?name gensym("ampsysM") ?itemText "Extract Current Schematic..." ?callback "ampsysExtractCurrentSchematic()")
      m3 = hiCreateMenuItem(?name gensym("ampsysM") ?itemText "Apply Last Result" ?callback "ampsysApplyLastResult()")
      pm = hiCreatePulldownMenu(gensym("ampsysPM") "AmpSys" list(m1 m2 m3))
      hiInsertBannerMenu(win pm hiGetNumMenus(win))
      _ampsysTagged = cons(win _ampsysTagged)
      ampsysLog(sprintf(nil "Menu added to window=%L" win))
    )
  )
)

errset(ampsysAddMenu(hiGetCIWindow()))

procedure(_ampsysScanWindows()
  let((ciw)
    ciw = hiGetCIWindow()
    foreach(win hiGetWindowList()
      when(win
        unless(or(equal(win ciw) member(win _ampsysTagged))
          errset(ampsysAddMenu(win))
        )
      )
    )
  )
  hiRegTimer("_ampsysScanWindows()" 2)
)

unless(_ampsysMenuTimerOn
  _ampsysMenuTimerOn = t
  hiRegTimer("_ampsysScanWindows()" 2)
  ampsysLog("Menu timer started.")
)

errset(hiSetBindKeys("Schematics" list(
  list("Ctrl Shift<Key>a" "ampsysExtractCurrentSchematic()")
)))

ampsysLog("Menu loaded. Shortcut: Ctrl+Shift+A in Schematics.")
